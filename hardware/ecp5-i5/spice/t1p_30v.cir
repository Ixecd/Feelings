T1-P sink @30V, Rsense=100, op-amp rail 12V
Vvs  vs 0 DC 30
Vop  vop 0 DC 12
Vvref vrefsrc 0 DC 0.5
Rvf  vrefsrc vref 10k

* op-amp on 12V rail, output clamp ~10.5V
Bop out 0 V = max(0.1, min(10.5, 1.0e4*(V(vref) - V(rs_top))))

Rg1 out qgate 1k
Rg2 qgate 0 100k
Cg  qgate 0 1n
Mqs B qgate rs_top rs_top M2N7000
Rrs rs_top 0 100
Crs rs_top 0 10p

* H-bridge ideal switches; final design = NO VS' limit
S1 mid1 vs a1 0 SW1
S2 mid2 B  a1 0 SW1
S3 mid2 vs a2 0 SW1
S4 mid1 B  a2 0 SW1
Rld mid1 mid2 2k

Va1 a1 0 PULSE(0 5 0    0.1u 0.1u 200u 1000u)
Va2 a2 0 PULSE(0 5 210u 0.1u 0.1u 200u 1000u)
Ben  en 0 V = max(V(a1), V(a2))
Benb nen 0 V = (V(en) > 2.5) ? 0 : 5
Rqbs nen qb 10k
Rqbp qb 0 100k
Qqd vref qb 0 0 Q2N3904

.model SW1 SW(Ron=2 Roff=1e12 Vt=2.5 Vh=0.3)
.model M2N7000 NMOS(Level=1 Vto=2.1 Kp=0.07 Lambda=0.01)
.model Q2N3904 NPN(Is=6.7e-15 Bf=200 Vaf=100 Rb=10 Cjc=4p Cje=5p)
.options reltol=1e-3 vntol=1e-4 abstol=1e-9 gmin=1e-9 itl4=200

.control
tran 0.05u 2500u
wrdata t1p_30v.txt v(rs_top) v(vref) v(qgate) v(mid1) v(mid2)
.endc
.end
