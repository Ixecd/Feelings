T1-P sink + ideal H-bridge, biphasic, WITH windup fix (QD)
Vvs   vs 0 DC 9
Vvref vrefsrc 0 DC 0.26
Rvf   vrefsrc vref 10k

* op-amp (clamped, gain 1e4)
Bop out 0 V = max(0.15, min(7.5, 1.0e4*(V(vref) - V(rs_top))))

* sink: QS + Rsense  (+ gate cap for convergence)
Rg1 out qgate 1k
Rg2 qgate 0 100k
Cg  qgate 0 1n
Mqs B qgate rs_top rs_top M2N7000
Rrs rs_top 0 390
Crs rs_top 0 10p

* H-bridge as ideal switches (VS' via 1k)
Rlim vs vsp 1k
S1 mid1 vsp a1 0 SW1
S2 mid2 B   a1 0 SW1
S3 mid2 vsp a2 0 SW1
S4 mid1 B   a2 0 SW1
Rld mid1 mid2 2.2k

* biphasic: pos 0-200u, neg 210-410u, period 1000u
Va1 a1 0 PULSE(0 5 0    0.1u 0.1u 200u 1000u)
Va2 a2 0 PULSE(0 5 210u 0.1u 0.1u 200u 1000u)
Ben  en 0 V = max(V(a1), V(a2))
Benb nen 0 V = (V(en) > 2.5) ? 0 : 5

* QD windup: pull vref low when !en
Rqbs nen qb 10k
Rqbp qb 0 100k
Qqd vref qb 0 0 Q2N3904

.model SW1 SW(Ron=2 Roff=1e12 Vt=2.5 Vh=0.3)
.model M2N7000 NMOS(Level=1 Vto=2.1 Kp=0.07 Lambda=0.01)
.model Q2N3904 NPN(Is=6.7e-15 Bf=200 Vaf=100 Rb=10 Cjc=4p Cje=5p)
.options reltol=1e-3 vntol=1e-4 abstol=1e-9 gmin=1e-9 itl4=200

.control
tran 0.05u 2500u
wrdata t1p_withqd.txt v(rs_top) v(vref) v(qgate) v(mid1) v(mid2)
.endc
.end
